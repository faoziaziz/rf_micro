** sch_path: /home/aziz-faozi/azizprojects/rf_ic/poweramp/poweramp2.sch
.include "/home/aziz-faozi/azizprojects/rf_ic/poweramp/mmbt2222.lib"
**.subckt poweramp2
R1 VOUT VIN 1k m=1
C1 VOUT GND 1p m=1
V1 VIN GND SIN(0 10m 1Meg)
V2 net1 GND 5
Q2 VOUT3 VOUT VOUT2 MMBT2222 area=1 m=1
L5 VOUT2 GND 1n m=1
R2 net1 VOUT3 1k m=1
**** begin user architecture code

.tran 100p 10n
.save all

**** end user architecture code
**.ends
.GLOBAL GND
.end
