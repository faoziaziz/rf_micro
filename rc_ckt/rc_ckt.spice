** sch_path: /home/aziz-faozi/azizprojects/rf_ic/rc_ckt/rc_ckt.sch
**.subckt rc_ckt
R1 VOUT VIN 1k m=1
C1 VOUT GND 1p m=1
V1 VIN GND PULSE(0 1 0.5n 100p 100p 1n 2n)
**** begin user architecture code

.tran 100p 10n
.save all

**** end user architecture code
**.ends
.GLOBAL GND
.end
